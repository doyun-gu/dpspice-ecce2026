* boost_async nominal load -- LTspice cross-check for the hybrid NR-HB path.
* Mirrors src/dpspice/data/examples/boost_async.sp including the 150 nF
* snubber and the diode model, so the comparison is against the same circuit
* the hybrid solver sees (snubber included). 50 kHz gate, d=0.6. Gate edges
* are an explicit 1 ns (a zero-edge PULSE is auto-limited to Ton/10,
* stretching the duty to 0.66 and the DC ~1.8 V high). Expect V(out) above
* Vin/(1-d) because the snubber injects charge. Output settle tau ~ 2RC =
* 4 ms; collection starts at 39.8 ms (~10 tau) so the tail is settled to
* sub-mV; .four over an integer 10 periods.
Vin vin 0 12
L1 vin sw 100u
S1 sw 0 g 0 SWMOD
D1 sw out DMOD
Csn sw 0 150n
C1 out 0 100u
Rl out 0 20
Vg g 0 PULSE(0 1 0 1n 1n 12u 20u)
.model SWMOD SW(Ron=20m Roff=1Meg Vt=0.5)
.model DMOD D(Is=1e-9 N=1)
.options plotwinsize=0
.tran 0 40m 39.8m 50n
.four 50k 8 10 V(out)
.end
