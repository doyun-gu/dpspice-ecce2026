* boost_sync d=0.5 CCM start-up -- LTspice cross-check for the LTP path.
* Ron/Roff/Vt match src/dpspice/data/examples/boost_sync.sp exactly; duty is
* set to 0.5 per the validation matrix (shipped example is d=0.6). 50 kHz gate
* pair, 400 points per switching period, .four on V(out) at the switching
* frequency for a per-harmonic comparison against the dpspice HB k-table.
Vin vin 0 12
L1 vin sw 100u
S1 sw 0 g 0 SWMOD
S2 sw out gb 0 SWMOD
C1 out 0 100u
Rl out 0 20
Vg  g  0 PULSE(0 1 0 0 0 10u 20u)
Vgb gb 0 PULSE(1 0 0 0 0 10u 20u)
.model SWMOD SW(Ron=20m Roff=1Meg Vt=0.5)
.options plotwinsize=0
.tran 0 5m 0 50n
.four 50k 8 V(out)
.end
