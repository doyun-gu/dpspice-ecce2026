* boost_async WITHOUT the snubber -- LTspice reference for the bare converter.
* Same circuit as boost_async_nom.cir minus Csn. The validation campaign found
* the un-snubbered circuit tracks the hybrid HB DC trend better; this deck
* pins the bare-converter reference independently and serves the
* continuation-solver convergence study. 1 ns gate edges; output settle
* tau ~ 2RC = 4 ms, collection starts at 39.8 ms (~10 tau), integer 10
* periods for the .four window.
Vin vin 0 12
L1 vin sw 100u
S1 sw 0 g 0 SWMOD
D1 sw out DMOD
C1 out 0 100u
Rl out 0 20
Vg g 0 PULSE(0 1 0 1n 1n 12u 20u)
.model SWMOD SW(Ron=20m Roff=1Meg Vt=0.5)
.model DMOD D(Is=1e-9 N=1)
.options plotwinsize=0
.tran 0 40m 39.8m 50n
.four 50k 8 10 V(out)
.end
