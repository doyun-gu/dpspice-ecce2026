* hybrid_mix -- LTspice cross-check for the hybrid NR-HB path.
* Mirrors src/dpspice/data/examples/hybrid_mix.sp exactly (gated switch feeding
* a diode rectifier, 100 uF smoothing). Line and gate fundamental is 50 Hz
* (20 ms period), so .four analyses at 50 Hz. maxstep 50 us gives 400 pts per
* fundamental period.
Vs in 0 SINE(0 10 50)
S1 in mid g 0 SWMOD
Rmid mid 0 1e9
D1 mid out DMOD
C1 out 0 100u
Rl out 0 1k
Vg g 0 PULSE(0 1 0 0 0 5m 20m)
.model SWMOD SW(Ron=1m Roff=1Meg Vt=0.5)
.model DMOD D(Is=1e-9 N=1)
.options plotwinsize=0
.tran 0 0.2 0 50u
.four 50 8 V(out)
.end
